* Laboratorio 5 - Circuito 2: Cerca de la saturación (BC548B, W1 = 150 mV pico, 1 kHz)
* R2=2700
VCC vcc 0 12
VW1 w1 0 SIN(0 0.15 1k)
CIN b w1 10u
R1 vcc b 10k
R2 b 0 2700
RC vcc c 2.2k
Q1 c b e BC548B
RE1 e e2 100
RE2 e2 0 390
CE e2 0 100u

.model BC548B NPN(IS=2.39E-14 NF=1.008 ISE=3.545E-15 NE=1.541 BF=294.3 IKF=0.1357 VAF=63.2 NR=1.004 ISC=6.272E-14 NC=1.243 BR=7.946 IKR=0.1144 VAR=25.9 RB=1 IRB=1E-06 RBM=1 RE=0.4683 RC=0.85 XTB=0 EG=1.11 XTI=3 CJE=1.358E-11 VJE=0.65 MJE=0.3279 TF=4.391E-10 XTF=120 VTF=2.643 ITF=0.7495 PTF=0 CJC=3.728E-12 VJC=0.3997 MJC=0.2955 XCJC=0.6193 TR=1E-32 FC=0.9579)
.model Q2N2222A NPN(IS=14.34f XTI=3 EG=1.11 VAF=74.03 BF=255.9 NE=1.307 ISE=14.34f IKF=.2847 XTB=1.5 BR=6.092 NC=2 ISC=0 IKR=0 RC=1 CJC=7.306p MJC=.3416 VJC=.75 FC=.5 CJE=22.01p MJE=.377 VJE=.75 TR=46.91n TF=411.1p ITF=.6 VTF=1.7 XTF=3 RB=10)

.control
set noaskquit
op
print v(b) v(e) v(c) @q1[ib] @q1[ic]
tran 2u 30m 0 2u
plot v(w1) v(c)
.endc
.end
