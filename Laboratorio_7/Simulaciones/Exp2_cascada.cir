* Practica 7 - Experimento 2b: emisor comun -> seguidor de emisor -> RL = 100 Ohm
.include modelos.lib
VCC vcc 0 12
VS in 0 dc 0 sin(0 20m 1k)
CIN in b 10u
R1 vcc b 10k
R2 b 0 1.8k
Q1 c b e BC548B
RC vcc c 2.2k
RE1 e e2 100
RE2 e2 0 390
CE e2 0 100u
CAC c b2 10u
R3 vcc b2 47k
R4 b2 0 47k
Q2 vcc b2 e3 Q2N2222A
RE3 e3 0 1k
COUT e3 o 100u
RL o 0 100
.control
set noaskquit
tran 10u 60m 40m
meas tran vinp PP v(in)
meas tran vcp PP v(c)
meas tran vop PP v(o)
let av1 = vcp/vinp
let av = vop/vinp
print av1 av
.endc
.end
