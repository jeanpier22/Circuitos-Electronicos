* Practica 7 - Experimento 3a: push-pull clase B, +-5 V, RL = 47 Ohm
.include modelos.lib
VP vp 0 5
VN vn 0 -5
VS s 0 dc 0 sin(0 3 1k)
RS s in 100
Q1 vp in o Q2N2222A
Q2 vn in o Q2N2907A
RL o 0 47
.control
set noaskquit
tran 2u 12m 8m
meas tran vinrms RMS v(in) from=8m to=12m
meas tran vorms RMS v(o) from=8m to=12m
meas tran vop MAX v(o) from=8m to=12m
meas tran iinrms RMS i(vs) from=8m to=12m
meas tran ipavg AVG i(vp) from=8m to=12m
meas tran inavg AVG i(vn) from=8m to=12m
let pout = vorms^2/47
let pin = vinrms*iinrms
let pdc = 5*(abs(ipavg)+abs(inavg))
print pout pin pdc pout/pin pout/pdc vorms/vinrms
wrdata exp3_claseB v(in) v(o)
.endc
.end
